simulator('spectre)

design("bforceLib" "bforceCell1" "schematic")
